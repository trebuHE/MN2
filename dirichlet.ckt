vT0 12 0 20
vTstart 1 0 100
vTend 11 0 40

r12 1 2 0.1
r23 2 3 0.1
r34 3 4 0.1
r45 4 5 0.1
r56 5 6 0.1
r67 6 7 0.1
r78 7 8 0.1
r89 8 9 0.1
r910 9 10 0.1
r1011 10 11 0.1

ra2 2 12 1000
ra3 3 12 1000
ra4 4 12 1000
ra5 5 12 1000
ra6 6 12 1000
ra7 7 12 1000
ra8 8 12 1000
ra9 9 12 1000
ra10 10 12 1000

iH2 0 2 50
iH3 0 3 50
iH4 0 4 50
iH5 0 5 50
iH6 0 6 50
iH7 0 7 50
iH8 0 8 50
iH9 0 9 50
iH10 0 10 50
